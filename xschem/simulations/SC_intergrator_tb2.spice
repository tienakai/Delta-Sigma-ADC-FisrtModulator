** sch_path: /home/designer/shared/Delta-sigma-adc/xschem/SC_intergrator_tb2.sch
**.subckt SC_intergrator_tb2
V1 Vcm GND 0.6
V2 Vin GND SIN(0 0.1 20k)
V3 vdd GND 1.2
V9 VBN GND 0.4
V10 VBP GND 0.2
V4 Vfb GND 0
V5 phi1 GND PULSE(0 1.2 0 1n 1n 40n 97.65625n)
V6 phi1n GND PULSE(1.2 0 0 1n 1n 40n 97.65625n)
V7 phi2 GND PULSE(0 1.2 55n 1n 1n 40n 97.65625n)
V8 phi2n GND PULSE(1.2 0 55n 1n 1n 40n 97.65625n)
x1 Vin Vfb phi1 phi1n phi2 phi2n VBN VBP vdd GND sc_int_out Vcm SC_integrator
**** begin user architecture code

.control
save all
tran 10n 200u
write Sc_intergrator_tb.raw
.endc

.lib cornerMOSlv.lib mos_tt
.lib cornerMOShv.lib mos_tt
.lib cornerHBT.lib hbt_typ
.lib cornerRES.lib res_typ
.lib cornerCAP.lib cap_typ

**** end user architecture code
**.ends

* expanding   symbol:  SC_integrator.sym # of pins=12
** sym_path: /home/designer/shared/Delta-sigma-adc/xschem/SC_integrator.sym
** sch_path: /home/designer/shared/Delta-sigma-adc/xschem/SC_integrator.sch
.subckt SC_integrator Vin Vfb phi1 phi1n phi2 phi2n VBN VBP vdd gnd sc_int_out Vcm
*.ipin Vin
*.ipin Vfb
*.ipin phi1
*.ipin phi1n
*.ipin phi2
*.ipin phi2n
*.ipin VBN
*.ipin VBP
*.iopin vdd
*.iopin gnd
*.opin sc_int_out
*.ipin Vcm
x1 Vin phi1 phi1n Vfb phi2 phi2n Vcm net1 vdd gnd switched_capacitor
x5 net1 Vcm VBN VBP sc_int_out vdd gnd Pseudo_compensated_self_cascode_OTA
XC2 net1 sc_int_out cap_cmim w=5.0e-6 l=5.0e-6 m=25
XC1 sc_int_out gnd cap_cmim w=5.0e-6 l=5.0e-6 m=53
.ends

* expanding   symbol:  switched_capacitor.sym # of pins=10
** sym_path: /home/designer/shared/Delta-sigma-adc/xschem/switched_capacitor.sym
** sch_path: /home/designer/shared/Delta-sigma-adc/xschem/switched_capacitor.sch
.subckt switched_capacitor Vin phi1 phi1n Vfb phi2 phi2n Vcm vout vdd gnd
*.ipin Vin
*.ipin phi1
*.ipin phi1n
*.ipin Vfb
*.ipin phi2
*.ipin phi2n
*.ipin Vcm
*.opin vout
*.iopin vdd
*.iopin gnd
x1 phi1n Vin sc_left gnd phi1 vdd T_gate
x2 phi2n Vfb sc_left gnd phi2 vdd T_gate
x3 phi1n Vcm sc_right gnd phi1 vdd T_gate
XC1 sc_left sc_right cap_cmim w=5.0e-6 l=5.0e-6 m=50
x4 phi2n sc_right vout gnd phi2 vdd T_gate
XC4 vout gnd cap_cmim w=5.0e-6 l=5.0e-6 m=100
.ends

* expanding   symbol:  Pseudo_compensated_self_cascode_OTA.sym # of pins=7
** sym_path: /home/designer/shared/Delta-sigma-adc/xschem/Pseudo_compensated_self_cascode_OTA.sym
** sch_path: /home/designer/shared/Delta-sigma-adc/xschem/Pseudo_compensated_self_cascode_OTA.sch
.subckt Pseudo_compensated_self_cascode_OTA VN VP V_BN V_BP V_OUT VDD VSS
*.ipin VN
*.ipin VP
*.ipin V_BN
*.ipin V_BP
*.opin V_OUT
*.iopin VDD
*.iopin VSS
XM11 net1 VN net2 VSS sg13_lv_nmos w=70u l=0.8u ng=7 m=1
XM12 V_GS VN net1 V_BP sg13_lv_nmos w=38.5u l=0.3u ng=4 m=1
XM21 net4 VP net2 VSS sg13_lv_nmos w=70u l=0.8u ng=7 m=1
XM22 VB32 VP net4 V_BP sg13_lv_nmos w=38.5u l=0.3u ng=4 m=1
XM52 net2 V_BN net3 V_BN sg13_lv_nmos w=40u l=0.5u ng=4 m=1
XM51 net3 V_BN VSS VSS sg13_lv_nmos w=40u l=2.5u ng=4 m=1
XM32 V_GS V_GS VS32 VB32 sg13_lv_pmos w=48.5u l=1.24u ng=5 m=1
XM31 VS32 V_GS VDD VDD sg13_lv_pmos w=48.5u l=0.87u ng=5 m=1
XM42 VB32 V_GS VS42 V_GS sg13_lv_pmos w=48.5u l=1.24u ng=5 m=1
XM41 VS42 V_GS VDD VDD sg13_lv_pmos w=48.5u l=0.87u ng=5 m=1
XM61 net5 VB32 VDD VDD sg13_lv_pmos w=60u l=0.13u ng=6 m=1
XM62 V_OUT VB32 net5 V_BP sg13_lv_pmos w=60u l=0.13u ng=6 m=1
XM72 V_OUT V_BN net6 V_BN sg13_lv_nmos w=40u l=0.5u ng=10 m=1
XM71 net6 V_BN VSS VSS sg13_lv_nmos w=40u l=2.5u ng=4 m=1
XC3 VS42 V_OUT cap_cmim w=5.0e-6 l=5.0e-6 m=38
XC1 net4 V_OUT cap_cmim w=5.0e-6 l=5.0e-6 m=38
.ends

* expanding   symbol:  T_gate.sym # of pins=6
** sym_path: /home/designer/shared/Delta-sigma-adc/xschem/T_gate.sym
** sch_path: /home/designer/shared/Delta-sigma-adc/xschem/T_gate.sch
.subckt T_gate !Control Vin Vout gnd Control vdd
*.iopin Vout
*.iopin Vin
*.iopin !Control
*.iopin Control
*.iopin gnd
*.iopin vdd
XM1 Vin Control Vout gnd sg13_lv_nmos w=1u l=0.13u ng=1 m=1
XM2 Vout !Control Vin vdd sg13_lv_pmos w=3u l=0.13u ng=1 m=1
.ends

.GLOBAL GND
.end
