* Extracted by KLayout with SG13G2 LVS runset on : 18/05/2026 11:13

.SUBCKT 1_bit_DAC VSS VDD Vin Vout vref_pos vref_neg
M$1 vref_pos Vin Vout VSS sg13_lv_nmos L=0.13u W=1u AS=0.34p AD=0.34p PS=2.68u
+ PD=2.68u
M$2 VSS Vin \$8 VSS sg13_lv_nmos L=0.13u W=0.4u AS=0.136p AD=0.136p PS=1.48u
+ PD=1.48u
M$3 vref_neg \$8 Vout VSS sg13_lv_nmos L=0.13u W=1u AS=0.34p AD=0.34p PS=2.68u
+ PD=2.68u
M$4 vref_pos \$8 Vout VDD sg13_lv_pmos L=0.13u W=3u AS=1.02p AD=1.02p PS=6.68u
+ PD=6.68u
M$5 VDD Vin \$8 VDD sg13_lv_pmos L=0.13u W=0.8u AS=0.272p AD=0.272p PS=2.28u
+ PD=2.28u
M$6 vref_neg Vin Vout VDD sg13_lv_pmos L=0.13u W=3u AS=1.02p AD=1.02p PS=6.68u
+ PD=6.68u
.ENDS 1_bit_DAC
