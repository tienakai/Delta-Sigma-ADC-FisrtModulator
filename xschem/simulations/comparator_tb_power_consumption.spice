** sch_path: /home/designer/shared/Delta-sigma-adc/xschem/comparator_tb_power_consumption.sch
**.subckt comparator_tb_power_consumption
C1 vout V_SS 1p m=1
Vin V_in GND PULSE(0.5 0.7 1u 1n 1n 10u 20u)
VDD V_DD GND 1.2
V_SS V_SS GND 0
x1 V_DD vout V_in V_inn V_SS comparator
Vin1 V_inn GND 0.6
**** begin user architecture code
 .lib cornerMOSlv.lib mos_tt

.control

tran 1n 20u

* ===== Total current =====
let i_total = -vdd#branch

plot i_total

meas tran I_total AVG i_total from=5e-6 to=20e-6

* ===== Power =====
let p_total = 1.2*i_total

plot p_total

meas tran P_total AVG p_total from=5e-6 to=20e-6

print I_total
print P_total
.endc

**** end user architecture code
**.ends

* expanding   symbol:  comparator.sym # of pins=5
** sym_path: /home/designer/shared/Delta-sigma-adc/xschem/comparator.sym
** sch_path: /home/designer/shared/Delta-sigma-adc/xschem/comparator.sch
.subckt comparator VDD out inn inp VSS
*.ipin inp
*.ipin inn
*.iopin VDD
*.iopin VSS
*.opin out
XM4 net2 net1 VDD VDD sg13_lv_pmos w=1.5u l=5u ng=1 m=1
XM3 net1 net1 VDD VDD sg13_lv_pmos w=1.5u l=5u ng=1 m=1
XM1 net1 inp net3 VSS sg13_lv_nmos w=1.5u l=5u ng=1 m=1
XM2 net2 inn net3 VSS sg13_lv_nmos w=1.5u l=5u ng=1 m=1
XM7 net4 net4 VDD VDD sg13_lv_pmos w=1.5u l=5u ng=1 m=1
XM8 out net2 VDD VDD sg13_lv_pmos w=1.5u l=5u ng=1 m=1
XM6 net4 net4 VSS VSS sg13_lv_nmos w=2.5u l=5u ng=1 m=1
XM5 net3 net4 VSS VSS sg13_lv_nmos w=1.5u l=5u ng=1 m=1
XM9 out net4 VSS VSS sg13_lv_nmos w=1.5u l=5u ng=1 m=1
.ends

.GLOBAL GND
.end
