** sch_path: /home/designer/shared/Delta-sigma-adc/xschem/test.sch
**.subckt test
Vgs G GND 0.5
Vds D GND 1.2
Vd D net1 0
.save i(vd)
Vb net2 GND 0.7
XM1 GND G net1 net2 sg13_lv_pmos w=3 l=0.13 ng=1 m=1
**** begin user architecture code

.lib cornerMOSlv.lib mos_tt
.lib cornerRES.lib res_typ

.param temp=27
.options savecurrents
.control
save all

show @n.xm1.nsg13_lv_pmos

* Save transistor parameters
save @n.xm1.nsg13_lv_pmos[vth]
save @n.xm1.nsg13_lv_pmos[vgs]
save @n.xm1.nsg13_lv_pmos[vds]
save @n.xm1.nsg13_lv_pmos[vgt]
save @n.xm1.nsg13_lv_pmos[ids]
save @n.xm1.nsg13_lv_pmos[gm]
save @n.xm1.nsg13_lv_pmos[gds]
save @n.xm1.nsg13_lv_pmos[gmb]
save @n.xm1.nsg13_lv_pmos[cgs]
save @n.xm1.nsg13_lv_pmos[cgd]
save @n.xm1.nsg13_lv_pmos[fug]
save @n.xm1.nsg13_lv_pmos[rg]

* Operating Point Analysis
op
remzerovec
write test.raw

quit
.endc

**** end user architecture code
**.ends
.GLOBAL GND
.end
