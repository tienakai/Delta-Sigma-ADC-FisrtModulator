** sch_path: /home/designer/shared/Delta-sigma-adc/xschem/comparator_tb_noise.sch
**.subckt comparator_tb_noise
Vin V_cm net1 dc 0 ac 1
VDD V_DD GND 1.2
V_SS V_SS GND 0
Vin3 V_cm V_SS 0.6
x1 V_DD v_out V_cm net1 V_SS comparator
C1 v_out V_SS 0.05p m=1
**** begin user architecture code

.temp 27
.control
option sparse
set filetype=ascii
save all

*op
*write comparator_tb_noise.raw
*set appendwrite

ac dec 101 1k 1G
*write OTA_tb_noise.raw
plot 20*log10(v_out)

noise v(v_out) Vin lin 1000 1MEG 1000MEG 1
print inoise_total
print onoise_total

setplot noise1
plot inoise_spectrum linplot
plot onoise_spectrum linplot

setplot noise2
write comparator_tb_noise.raw

.endc

 .lib cornerMOSlv.lib mos_tt

 .include /home/designer/shared/Delta-sigma-adc/xschem/comparator_tb_noise.save

**** end user architecture code
**.ends

* expanding   symbol:  comparator.sym # of pins=5
** sym_path: /home/designer/shared/Delta-sigma-adc/xschem/comparator.sym
** sch_path: /home/designer/shared/Delta-sigma-adc/xschem/comparator.sch
.subckt comparator VDD out inn inp VSS
*.ipin inp
*.ipin inn
*.iopin VDD
*.iopin VSS
*.opin out
XM4 net2 net1 VDD VDD sg13_lv_pmos w=1.5u l=5u ng=1 m=1
XM3 net1 net1 VDD VDD sg13_lv_pmos w=1.5u l=5u ng=1 m=1
XM1 net1 inp net3 VSS sg13_lv_nmos w=1.5u l=5u ng=1 m=1
XM2 net2 inn net3 VSS sg13_lv_nmos w=1.5u l=5u ng=1 m=1
XM7 net4 net4 VDD VDD sg13_lv_pmos w=1.5u l=5u ng=1 m=1
XM8 out net2 VDD VDD sg13_lv_pmos w=1.5u l=5u ng=1 m=1
XM6 net4 net4 VSS VSS sg13_lv_nmos w=2.5u l=5u ng=1 m=1
XM5 net3 net4 VSS VSS sg13_lv_nmos w=1.5u l=5u ng=1 m=1
XM9 out net4 VSS VSS sg13_lv_nmos w=1.5u l=5u ng=1 m=1
.ends

.GLOBAL GND
.end
